* G.O.S. sensor node: battery measurement divider into the nRF52840 SAADC (AIN0)
* R10/R11 2.2 M 1 %, C 100 nF (board). The SAADC samples through a small capacitor
* (assumed 5 pF, 40 us acquisition) once per reading; the 100 nF holds the node steady.
* Cell steps from 3.0 V to 4.2 V at 1 s (charger plugged in).
* Steps: resistor tolerance corners (+/-1 % on each resistor).

.param tol1=0 tol2=0
Vbat vbat 0 PWL(0 3.0 1 3.0 1.001 4.2)
R10 vbat sense {2.2Meg*(1+tol1)}
R11 sense 0 {2.2Meg*(1+tol2)}
C1 sense 0 100n
* SAADC sample: 5 pF connected for 40 us every 100 ms through 1 k
Ssamp sense samp clk 0 SAMP
Csamp samp 0 5p
Rleak samp 0 100Meg
Vclk clk 0 PULSE(0 1 50m 1n 1n 40u 100m)
.model SAMP SW(Ron=1k Roff=1G Vt=0.5)

.tran 0 3 0 1m
.step param tol1 list -0.01 0.01
.step param tol2 list -0.01 0.01

.meas TRAN V_sense_end FIND V(sense) AT 2.9
.meas TRAN ratio_error PARAM (V_sense_end/4.2 - 0.5)/0.5
.meas TRAN t_settle FIND time WHEN V(sense)=2.079 RISE=1
.meas TRAN settle_time PARAM t_settle-1.001
.meas TRAN I_drain AVG I(R10) FROM 2.5 TO 2.9
.end
